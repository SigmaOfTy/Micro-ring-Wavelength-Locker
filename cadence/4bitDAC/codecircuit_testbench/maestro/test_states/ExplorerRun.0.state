ADE simulation setup
Test 8bitDACLL:codecircuit_testbench:1: 8bitDACLL/codecircuit_testbench/schematic, simulator spectre
  Models: /home/colon/PDK/project_tsmc65/project_tsmc65/TSMC-65nm(OA)/models/spectre/toplevel.scs[tt_lib]
  Temperature: 27
  Analysis tran: stop=100u errpreset=liberal
  Signals: /A, /B, /C, /D, /vn0, /vn1, /vn2, /vn3, /vn4, /vn5, /vn6, /vn7, /vn8, /vn9, /vn10, /vn11, /vn12, /vn13, /vn14, /vp0, /vp1, /vp2, /vp3, /vp4, /vp5, /vp6, /vp7, /vp8, /vp9, /vp10, /vp11, /vp12, /vp13, /vp14
