ADE simulation setup
Test 8bitDACLL:8bdac_testbench2:1: 8bitDACLL/8bdac_testbench2/schematic, simulator spectre
  Models: /home/IC/Tech/TSMC-65nm(OA)/tsmcN65/../models/spectre/toplevel.scs[tt_lib]
  Temperature: 27
  Analysis tran: stop=1m errpreset=liberal
  Signals: /vin, /V+, /V-
