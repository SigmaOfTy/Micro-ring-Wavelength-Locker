ADE simulation setup
Test 12bitdac_LL116:12bit:1: 12bitdac_LL116/12bit/schematic, simulator spectre
  Models: /opt/PDK/TSMC/PDK_CRN65LP_v1.7a_Official_IC61/tsmcN65/../models/spectre/toplevel.scs[tt_lib]
  Temperature: 27
  Analysis tran: stop=10m errpreset=moderate
  Signals: /V+, /V-
