ADE simulation setup
Run mode: Single Run, Sweeps and Corners
Tests:
  12bitdac_LL116:12bit:1: 12bitdac_LL116/12bit/schematic, simulator spectre
    Outputs: /D1; /D0; /D2; /D3; /D4; /D5; /D6; /D7; /D8; /D9; /D10; /D11; /V1+; /V1-; /V2+; /V2-; /V+; /V-
