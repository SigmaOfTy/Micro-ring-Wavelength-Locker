ADE simulation setup
Run mode: Single Run, Sweeps and Corners
Tests:
  8bitDACLL:8bdac_testbench:1: 8bitDACLL/8bdac_testbench/schematic, simulator spectre
