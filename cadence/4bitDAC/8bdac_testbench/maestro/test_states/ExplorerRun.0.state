ADE simulation setup
Test 8bitDACLL:8bdac_testbench:1: 8bitDACLL/8bdac_testbench/schematic, simulator spectre
  Models: /home/colon/PDK/project_tsmc65/project_tsmc65/TSMC-65nm(OA)/models/spectre/toplevel.scs[tt_lib]
  Temperature: 27
  Analysis tran: stop=512u errpreset=moderate
  Signals: /D0, /D1, /D2, /D3, /D4, /D5, /D6, /D7, /V+, /V-
